* SPICE NETLIST
***************************************

.SUBCKT crtmom PLUS MINUS BULK
.ENDS
***************************************
.SUBCKT cfmom PLUS MINUS BULK
.ENDS
***************************************
.SUBCKT cfmom_mx PLUS1 MINUS1 PLUS2 MINUS2 BULK
.ENDS
***************************************
.SUBCKT efuse PLUS MINUS
.ENDS
***************************************
.SUBCKT hvpwdpwnblhvnw_dio_hvpw_gb_3t PLUS MINUS SUB
.ENDS
***************************************
.SUBCKT hvpwnblhvnw_dio_hvpw_gb_3t PLUS MINUS SUB
.ENDS
***************************************
.SUBCKT hvpwnblhvnw_esd_dio_hvpw_gb_3t PLUS MINUS SUB
.ENDS
***************************************
.SUBCKT mimcap_1p0_sin TOP BOT
.ENDS
***************************************
.SUBCKT mimcap_1p0_sin_3t PLUS MINUS BULK
.ENDS
***************************************
.SUBCKT mimcap_1p0_sin_hl TOP BOT
.ENDS
***************************************
.SUBCKT mimcap_1p0_sin_hl_3t PLUS MINUS BULK
.ENDS
***************************************
.SUBCKT mimcap_2p0_sin TOP BOT
.ENDS
***************************************
.SUBCKT mimcap_2p0_sin_3t PLUS MINUS BULK
.ENDS
***************************************
.SUBCKT na12_g5a_nbl_mr_mac D G S B SUB
.ENDS
***************************************
.SUBCKT na29_g5a_mac D G S B
.ENDS
***************************************
.SUBCKT na45_g5b_mac D G S B SUB
.ENDS
***************************************
.SUBCKT na6_g5a_nbl_mac D G S B SUB
.ENDS
***************************************
.SUBCKT na70_g5b_mac D G BS SUB
.ENDS
***************************************
.SUBCKT na7_g5a_nbl_mr_mac D G S B SUB
.ENDS
***************************************
.SUBCKT nch_5_switch_hvnwnbl29_mac D G BS NBL_ISO SUB
.ENDS
***************************************
.SUBCKT nch_5_switch_hvnwnbl8_mac D G BS NBL_ISO SUB
.ENDS
***************************************
.SUBCKT nch_5_switch_hvpwdpwnbl45_mac D G BS NBL_ISO SUB
.ENDS
***************************************
.SUBCKT nch_5_switch_hvpwdpwnbl70_mac D G BS NBL_ISO SUB
.ENDS
***************************************
.SUBCKT nch_5_switch_low_ron_hvnwnbl29_mac D G BS NBL_ISO SUB
.ENDS
***************************************
.SUBCKT nch_5_switch_low_ron_hvnwnbl8_mac D G BS NBL_ISO SUB
.ENDS
***************************************
.SUBCKT nch_5_switch_low_ron_hvpwdpwnbl45_mac D G BS NBL_ISO SUB
.ENDS
***************************************
.SUBCKT nch_5_switch_low_ron_hvpwdpwnbl70_mac D G BS NBL_ISO SUB
.ENDS
***************************************
.SUBCKT nch_5_switch_low_ron_mac D G BS
.ENDS
***************************************
.SUBCKT nch_5_switch_low_ron_shpdpwnbl29_mac D G BS NBL_ISO SUB
.ENDS
***************************************
.SUBCKT nch_5_switch_low_ron_shpdpwnbl8_mac D G BS NBL_ISO SUB
.ENDS
***************************************
.SUBCKT nch_5_switch_mac D G BS
.ENDS
***************************************
.SUBCKT nch_5_switch_shpdpwnbl29_mac D G BS NBL_ISO SUB
.ENDS
***************************************
.SUBCKT nch_5_switch_shpdpwnbl8_mac D G BS NBL_ISO SUB
.ENDS
***************************************
.SUBCKT nch_hv5_5vnw_ac D G S B
.ENDS
***************************************
.SUBCKT nda20_g3a_mac D G S B SUB
.ENDS
***************************************
.SUBCKT nda24_g3b_mac D G S B SUB
.ENDS
***************************************
.SUBCKT nda29_g3a_nbl_mac D G S B SUB
.ENDS
***************************************
.SUBCKT nda45_g3b_mac D G BS SUB
.ENDS
***************************************
.SUBCKT nda65_g3b_mac D G BS SUB
.ENDS
***************************************
.SUBCKT nda6_g3a_mac D G S B SUB
.ENDS
***************************************
.SUBCKT ndio_sbd_mac PLUS MINUS
.ENDS
***************************************
.SUBCKT nhvpwnbl10_gb_4t C B E SUB
.ENDS
***************************************
.SUBCKT nhvpwnbl2_gb_4t C B E SUB
.ENDS
***************************************
.SUBCKT nhvpwnbl5_gb_4t C B E SUB
.ENDS
***************************************
.SUBCKT nld12_g5a_iso_hp_mac D G BS NBL_ISO SUB
.ENDS
***************************************
.SUBCKT nld12_g5a_iso_mac D G BS NBL_ISO SUB
.ENDS
***************************************
.SUBCKT nld12_g5a_nbl_hp_mac D G BS SUB
.ENDS
***************************************
.SUBCKT nld12_g5a_nbl_mac D G BS SUB
.ENDS
***************************************
.SUBCKT nld12_g5a_nbl_mr_mac D G BS SUB
.ENDS
***************************************
.SUBCKT nld16_g5a_iso_mac D G BS NBL_ISO SUB
.ENDS
***************************************
.SUBCKT nld16_g5a_nbl_mac D G BS SUB
.ENDS
***************************************
.SUBCKT nld20_g5a_iso_mac D G BS NBL_ISO SUB
.ENDS
***************************************
.SUBCKT nld20_g5a_nbl_mac D G BS SUB
.ENDS
***************************************
.SUBCKT nld20_g5b_mac D G BS SUB
.ENDS
***************************************
.SUBCKT nld24_g5a_nbl_mac D G BS SUB
.ENDS
***************************************
.SUBCKT nld24_g5b_mac D G BS SUB
.ENDS
***************************************
.SUBCKT nld36_g5a_mac D G BS
.ENDS
***************************************
.SUBCKT nld36_g5b_mac D G BS SUB
.ENDS
***************************************
.SUBCKT nld45_g5b_mac D G BS SUB
.ENDS
***************************************
.SUBCKT nld55_g5b_mac D G BS SUB
.ENDS
***************************************
.SUBCKT nld65_g5b_mac D G BS SUB
.ENDS
***************************************
.SUBCKT nld6_g5a_de_iso_mac D G BS NBL_ISO SUB
.ENDS
***************************************
.SUBCKT nld6_g5a_de_nbl_mac D G BS SUB
.ENDS
***************************************
.SUBCKT nld6_g5a_sa_iso_mac D G BS NBL_ISO SUB
.ENDS
***************************************
.SUBCKT nld6_g5a_sa_nbl_mac D G BS SUB
.ENDS
***************************************
.SUBCKT nld7_g5a_nbl_mr_mac D G BS SUB
.ENDS
***************************************
.SUBCKT nld8_g5a_iso_mac D G BS NBL_ISO SUB
.ENDS
***************************************
.SUBCKT nld8_g5a_nbl_mac D G BS SUB
.ENDS
***************************************
.SUBCKT nmoscap PLUS MINUS
.ENDS
***************************************
.SUBCKT nmoscap_5 PLUS MINUS
.ENDS
***************************************
.SUBCKT nmoscap_5_mis PLUS MINUS
.ENDS
***************************************
.SUBCKT npwhvnwnbl10_ga_4t C B E SUB
.ENDS
***************************************
.SUBCKT npwhvnwnbl10_ga_bgr8_7t C1 C8 B1 B8 E1 E8 SUB
.ENDS
***************************************
.SUBCKT npwhvnwnbl10_ga_poly_4t C B E SUB
.ENDS
***************************************
.SUBCKT npwhvnwnbl2_ga_4t C B E SUB
.ENDS
***************************************
.SUBCKT npwhvnwnbl2_ga_poly_4t C B E SUB
.ENDS
***************************************
.SUBCKT npwhvnwnbl5_ga_4t C B E SUB
.ENDS
***************************************
.SUBCKT npwhvnwnbl5_ga_poly_4t C B E SUB
.ENDS
***************************************
.SUBCKT nsw28bv_g5a_low_ron_mac D G BS NBL_ISO SUB
.ENDS
***************************************
.SUBCKT nsw28bv_g5a_low_ron_nb_mac D G S B NBL_ISO SUB
.ENDS
***************************************
.SUBCKT nsw40bv_g5a_low_ron_mac D G BS NBL_ISO SUB
.ENDS
***************************************
.SUBCKT nsw50bv_g5b_low_ron_mac D G BS
.ENDS
***************************************
.SUBCKT nwhvpwnbl10_gb_4t C B E SUB
.ENDS
***************************************
.SUBCKT nwhvpwnbl10_gb_bgr8_7t C1 C8 B1 B8 E1 E8 SUB
.ENDS
***************************************
.SUBCKT nwhvpwnbl10_gb_poly_4t C B E SUB
.ENDS
***************************************
.SUBCKT nwhvpwnbl2_gb_4t C B E SUB
.ENDS
***************************************
.SUBCKT nwhvpwnbl2_gb_poly_4t C B E SUB
.ENDS
***************************************
.SUBCKT nwhvpwnbl5_gb_4t C B E SUB
.ENDS
***************************************
.SUBCKT nwhvpwnbl5_gb_poly_4t C B E SUB
.ENDS
***************************************
.SUBCKT pa12_g5a_nbl_mac D G S B SUB
.ENDS
***************************************
.SUBCKT pa12_g5a_nbl_mr_mac D G S B SUB
.ENDS
***************************************
.SUBCKT pa16_g5a_nbl_mac D G S B SUB
.ENDS
***************************************
.SUBCKT pa20_g5a_nbl_mac D G S B SUB
.ENDS
***************************************
.SUBCKT pa20_g5b_mac D G S B SUB
.ENDS
***************************************
.SUBCKT pa29_g5a_nbl_mac D G S B SUB
.ENDS
***************************************
.SUBCKT pa36_g5b_mac D G S B SUB
.ENDS
***************************************
.SUBCKT pa45_g5b_mac D G S B SUB
.ENDS
***************************************
.SUBCKT pa55_g5b_mac D G S B SUB
.ENDS
***************************************
.SUBCKT pa6_g5a_de_nbl_mac D G S B SUB
.ENDS
***************************************
.SUBCKT pa6_g5a_sa_nbl_mac D G S B SUB
.ENDS
***************************************
.SUBCKT pa70_g5b_mac D G S B SUB
.ENDS
***************************************
.SUBCKT pa8_g5a_nbl_mac D G S B SUB
.ENDS
***************************************
.SUBCKT pbhvnw_dio_shp_ga_3t PLUS MINUS SUB
.ENDS
***************************************
.SUBCKT pbhvnwnbl_dio_hvpw_gb_3t PLUS MINUS SUB
.ENDS
***************************************
.SUBCKT pbhvnwnbl_dio_shp_ga_3t PLUS MINUS SUB
.ENDS
***************************************
.SUBCKT pbhvnwnbl_esd_dio_shp_ga_3t PLUS MINUS SUB
.ENDS
***************************************
.SUBCKT pbhvnwnblhvpw2_lat_gb_4t C B E SUB
.ENDS
***************************************
.SUBCKT pbhvnwnblhvpw5_lat_gb_4t C B E SUB
.ENDS
***************************************
.SUBCKT pbhvnwnblshp2_lat_ga_4t C B E SUB
.ENDS
***************************************
.SUBCKT pbhvnwnblshp5_lat_ga_4t C B E SUB
.ENDS
***************************************
.SUBCKT pbhvnwpsub10_gb_bgr8_5t CC B1 B8 E1 E8
.ENDS
***************************************
.SUBCKT pch_5_switch_low_ron_hvnwnbl29_mac D G S B SHP_ISO SUB
.ENDS
***************************************
.SUBCKT pch_5_switch_low_ron_hvnwnbl8_mac D G S B SHP_ISO SUB
.ENDS
***************************************
.SUBCKT pch_5_switch_low_ron_hvpwdpwnbl45_mac D G S B DPW_ISO NBL_ISO SUB
.ENDS
***************************************
.SUBCKT pch_5_switch_low_ron_hvpwdpwnbl70_mac D G S B DPW_ISO NBL_ISO SUB
.ENDS
***************************************
.SUBCKT pch_5_switch_low_ron_mac D G S B SUB
.ENDS
***************************************
.SUBCKT pch_5_switch_low_ron_shpdpwnbl29_mac D G S B DPW_ISO NBL_ISO SUB
.ENDS
***************************************
.SUBCKT pch_5_switch_low_ron_shpdpwnbl8_mac D G S B DPW_ISO NBL_ISO SUB
.ENDS
***************************************
.SUBCKT pch_5_switch_low_ron_slit_hvnwnbl29_mac D G BS SHP_ISO SUB
.ENDS
***************************************
.SUBCKT pch_5_switch_low_ron_slit_hvnwnbl8_mac D G BS SHP_ISO SUB
.ENDS
***************************************
.SUBCKT pch_5_switch_low_ron_slit_hvpwdpwnbl45_mac D G BS DPW_ISO NBL_ISO SUB
.ENDS
***************************************
.SUBCKT pch_5_switch_low_ron_slit_hvpwdpwnbl70_mac D G BS DPW_ISO NBL_ISO SUB
.ENDS
***************************************
.SUBCKT pch_5_switch_low_ron_slit_mac D G BS SUB
.ENDS
***************************************
.SUBCKT pch_5_switch_low_ron_slit_shpdpwnbl29_mac D G BS DPW_ISO NBL_ISO SUB
.ENDS
***************************************
.SUBCKT pch_5_switch_low_ron_slit_shpdpwnbl8_mac D G BS DPW_ISO NBL_ISO SUB
.ENDS
***************************************
.SUBCKT pch_5_switch_slit_hvnwnbl29_mac D G BS SHP_ISO SUB
.ENDS
***************************************
.SUBCKT pch_5_switch_slit_hvnwnbl8_mac D G BS SHP_ISO SUB
.ENDS
***************************************
.SUBCKT pch_5_switch_slit_hvpwdpwnbl45_mac D G BS DPW_ISO NBL_ISO SUB
.ENDS
***************************************
.SUBCKT pch_5_switch_slit_hvpwdpwnbl70_mac D G BS DPW_ISO NBL_ISO SUB
.ENDS
***************************************
.SUBCKT pch_5_switch_slit_mac D G BS SUB
.ENDS
***************************************
.SUBCKT pch_5_switch_slit_shpdpwnbl29_mac D G BS DPW_ISO NBL_ISO SUB
.ENDS
***************************************
.SUBCKT pch_5_switch_slit_shpdpwnbl8_mac D G BS DPW_ISO NBL_ISO SUB
.ENDS
***************************************
.SUBCKT pddhvnw_dio_shp_ga_3t PLUS MINUS SUB
.ENDS
***************************************
.SUBCKT pddhvnwnbl_dio_shp_ga_3t PLUS MINUS SUB
.ENDS
***************************************
.SUBCKT pdio_esd_ga_12_tlm_3t PLUS MINUS SUB
.ENDS
***************************************
.SUBCKT pdio_esd_ga_12_v2_3t PLUS MINUS SUB
.ENDS
***************************************
.SUBCKT pdio_esd_ga_16_tlm_3t PLUS MINUS SUB
.ENDS
***************************************
.SUBCKT pdio_esd_ga_6_3t PLUS MINUS SUB
.ENDS
***************************************
.SUBCKT pdio_esd_ga_8_3t PLUS MINUS SUB
.ENDS
***************************************
.SUBCKT pdio_esd_ga_nbl_16_v2_3t PLUS MINUS SUB
.ENDS
***************************************
.SUBCKT pdio_esd_ga_nbl_20_tlm_3t PLUS MINUS SUB
.ENDS
***************************************
.SUBCKT pdio_esd_ga_nbl_20_v2_3t PLUS MINUS SUB
.ENDS
***************************************
.SUBCKT pdio_esd_ga_nbl_24_tlm_3t PLUS MINUS SUB
.ENDS
***************************************
.SUBCKT pdio_esd_ga_nbl_24_v2_3t PLUS MINUS SUB
.ENDS
***************************************
.SUBCKT pdio_esd_ga_nbl_29_tlm_3t PLUS MINUS SUB
.ENDS
***************************************
.SUBCKT pdio_esd_ga_nbl_29_v2_3t PLUS MINUS SUB
.ENDS
***************************************
.SUBCKT pdio_esd_gb_20_3t PLUS MINUS SUB
.ENDS
***************************************
.SUBCKT pdio_esd_gb_24_3t PLUS MINUS SUB
.ENDS
***************************************
.SUBCKT pdio_esd_gb_36_3t PLUS MINUS SUB
.ENDS
***************************************
.SUBCKT pdio_esd_gb_45_3t PLUS MINUS SUB
.ENDS
***************************************
.SUBCKT pdio_esd_gb_55_3t PLUS MINUS SUB
.ENDS
***************************************
.SUBCKT pdio_esd_gb_65_3t PLUS MINUS SUB
.ENDS
***************************************
.SUBCKT phvnw_dio_hvpw_gb_3t PLUS MINUS SUB
.ENDS
***************************************
.SUBCKT phvnw_dio_shp_ga_3t PLUS MINUS SUB
.ENDS
***************************************
.SUBCKT rhim PLUS MINUS
.ENDS
***************************************
.SUBCKT rhvnwshp_ga PLUS MINUS SUB
.ENDS
***************************************
.SUBCKT rhvpwnblhvnw_hvpw_gb_4t PLUS MINUS NBL_ISO SUB
.ENDS
***************************************
.SUBCKT rhvpwnblhvnw_hvpw_gb_ck3_4t PLUS MINUS NBL_ISO SUB
.ENDS
***************************************
.SUBCKT rnddshp_ga PLUS MINUS SUB
.ENDS
***************************************
.SUBCKT rnddshp_ga_ck3 PLUS MINUS SUB
.ENDS
***************************************
.SUBCKT rnod_m PLUS MINUS B
.ENDS
***************************************
.SUBCKT rnodrpo_m PLUS MINUS B
.ENDS
***************************************
.SUBCKT rnodrpo_pure5v PLUS MINUS
.ENDS
***************************************
.SUBCKT rnodrpo_pure5v_m PLUS MINUS B
.ENDS
***************************************
.SUBCKT rnodw_m PLUS MINUS B
.ENDS
***************************************
.SUBCKT rnpo1_dis PLUS MINUS B
.ENDS
***************************************
.SUBCKT rnpo1rpo_dis PLUS MINUS B
.ENDS
***************************************
.SUBCKT rnpo1rpo_pure5v PLUS MINUS
.ENDS
***************************************
.SUBCKT rnpo1rpo_pure5v_dis PLUS MINUS B
.ENDS
***************************************
.SUBCKT rnpo1w_dis PLUS MINUS B
.ENDS
***************************************
.SUBCKT rnwod_m PLUS MINUS B
.ENDS
***************************************
.SUBCKT rnwod_pure5v PLUS MINUS
.ENDS
***************************************
.SUBCKT rnwod_pure5v_m PLUS MINUS B
.ENDS
***************************************
.SUBCKT rnwsti_m PLUS MINUS B
.ENDS
***************************************
.SUBCKT rnwsti_pure5v PLUS MINUS
.ENDS
***************************************
.SUBCKT rnwsti_pure5v_m PLUS MINUS B
.ENDS
***************************************
.SUBCKT rpddhvnw_shp_ga_4t PLUS MINUS HVNW_ISO SUB
.ENDS
***************************************
.SUBCKT rpod_m PLUS MINUS B
.ENDS
***************************************
.SUBCKT rpodrpo_m PLUS MINUS B
.ENDS
***************************************
.SUBCKT rpodrpo_pure5v PLUS MINUS
.ENDS
***************************************
.SUBCKT rpodrpo_pure5v_m PLUS MINUS B
.ENDS
***************************************
.SUBCKT rpodw_m PLUS MINUS B
.ENDS
***************************************
.SUBCKT rppo1_dis PLUS MINUS B
.ENDS
***************************************
.SUBCKT rppo1rpo_dis PLUS MINUS B
.ENDS
***************************************
.SUBCKT rppo1rpo_pure5v PLUS MINUS
.ENDS
***************************************
.SUBCKT rppo1rpo_pure5v_dis PLUS MINUS B
.ENDS
***************************************
.SUBCKT rppo1w_dis PLUS MINUS B
.ENDS
***************************************
.SUBCKT rppolyhri3k PLUS MINUS
.ENDS
***************************************
.SUBCKT rppolyhri3k_dis PLUS MINUS BULK
.ENDS
***************************************
.SUBCKT rppolyhri_dis PLUS MINUS B
.ENDS
***************************************
.SUBCKT rppolyhri_serp PLUS MINUS
.ENDS
***************************************
.SUBCKT rppolyhri_serp_dis PLUS MINUS SUB
.ENDS
***************************************
.SUBCKT rppolywo_serp PLUS MINUS
.ENDS
***************************************
.SUBCKT rppolywo_serp_dis PLUS MINUS SUB
.ENDS
***************************************
.SUBCKT rshphvnw_hvpw_gb_4t PLUS MINUS HVNW_ISO SUB
.ENDS
***************************************
.SUBCKT rshphvnw_shp_ga_4t PLUS MINUS HVNW_ISO SUB
.ENDS
***************************************
.SUBCKT sbd_dio_ga_12_3t PLUS MINUS SUB
.ENDS
***************************************
.SUBCKT sbd_dio_ga_16_3t PLUS MINUS SUB
.ENDS
***************************************
.SUBCKT sbd_dio_ga_24_3t PLUS MINUS SUB
.ENDS
***************************************
.SUBCKT sbd_dio_gb_30_3t PLUS MINUS SUB
.ENDS
***************************************
.SUBCKT sbd_dio_gb_36_3t PLUS MINUS SUB
.ENDS
***************************************
.SUBCKT shphvnw_dio_hvpw_gb_3t PLUS MINUS SUB
.ENDS
***************************************
.SUBCKT shphvnw_dio_shp_ga_3t PLUS MINUS SUB
.ENDS
***************************************
.SUBCKT shphvnwnbl_dio_hvpw_gb_3t PLUS MINUS SUB
.ENDS
***************************************
.SUBCKT shphvnwnbl_dio_shp_ga_3t PLUS MINUS SUB
.ENDS
***************************************
.SUBCKT zd_dio_ga_4t PLUS MINUS HVNW_ISO SUB
.ENDS
***************************************
.SUBCKT zd_dio_ga_nbl_4t PLUS MINUS NBL_ISO SUB
.ENDS
***************************************
.SUBCKT zd_dio_gb_4t PLUS MINUS NBL_ISO SUB
.ENDS
***************************************
.SUBCKT NAND VA VB VSS VDD VOUT
** N=6 EP=5 IP=0 FDC=6
M0 6 VB VSS VSS N L=1.8e-07 W=1e-06 $X=13400 $Y=-15550 $D=0
M1 6 VA VOUT VSS N L=1.8e-07 W=1e-06 $X=13400 $Y=-11400 $D=0
M2 VOUT VA VDD VDD P L=1.8e-07 W=1.71e-06 $X=8900 $Y=-5400 $D=14
M3 VDD VB VOUT VDD P L=1.8e-07 W=1.71e-06 $X=17150 $Y=-5400 $D=14
D4 VSS VDD pnwdio_iso AREA=6.4764e-12 pj=1.018e-05 $X=7470 $Y=-5830 $D=226
D5 VSS VDD pnwdio_iso AREA=6.4764e-12 pj=1.018e-05 $X=16240 $Y=-5830 $D=226
.ENDS
***************************************
.SUBCKT FULL_ADDER CIN VB VA VSS VDD COUT SUM
** N=14 EP=7 IP=45 FDC=54
X0 VA VB VSS VDD 6 NAND $T=-2400 -100 0 0 $X=500 $Y=-18600
X1 6 VB VSS VDD 7 NAND $T=27600 -24900 0 0 $X=30500 $Y=-43400
X2 VA 6 VSS VDD 8 NAND $T=27600 23200 0 0 $X=30500 $Y=4700
X3 8 7 VSS VDD 9 NAND $T=57600 -200 0 0 $X=60500 $Y=-18700
X4 9 CIN VSS VDD 10 NAND $T=90600 -700 0 0 $X=93500 $Y=-19200
X5 10 CIN VSS VDD 11 NAND $T=132700 -24900 0 0 $X=135600 $Y=-43400
X6 9 10 VSS VDD 12 NAND $T=132700 23200 0 0 $X=135600 $Y=4700
X7 12 11 VSS VDD SUM NAND $T=162700 -200 0 0 $X=165600 $Y=-18700
X8 10 6 VSS VDD COUT NAND $T=162900 -60000 0 0 $X=165800 $Y=-78500
.ENDS
***************************************
